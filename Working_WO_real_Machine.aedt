# Ansys Electronics Desktop project, version 2019.1

design Working_WO_real_Machine (Twin Builder)
options: SimplorerConverter(2385)
components:
  E4 = E(Type=ETRIANG PERIO=0 EMF=0.8V AMPL=1V FREQ=2000Hz TPERIO=Tend+1)
  gnd1 = gnd()
  C2NC6 = C2NC()
  AM3 = AM(I=0A)
  AM2 = AM(I=0A)
  AM1 = AM(I=0A)
  R4 = R(R=1ohm)
  R5 = R(R=1ohm)
  R6 = R(R=1ohm)
  L4 = L(L=2.25mH)
  L5 = L(L=2.25mH)
  L6 = L(L=2.25mH)
  VM8 = VM()
  VM9 = VM()
  VM10 = VM()
  VM11 = VM()
  gnd6 = gnd()
  E5 = E(EMF=200V PERIO=0)
  D7 = D()
  D8 = D()
  D9 = D()
  D10 = D()
  D11 = D()
  D12 = D()
  E6 = E(EMF=200V PERIO=0)
  gnd7 = gnd()
  motor_pm1 = motor_pm(l_d=0.01 l_q=0.01 lambda_pm=0.175 r_s=1.056 p=12 inertia=0.00075 phi_eo=0 omega_eo=0 rpm=0)
  MchRMas1 = MchRMas(J=0.00025kgm2 dALPHA=0rad_per_sec2)
  lowpass_filter_elec1 = lowpass_filter_elec(fp=55)
  R1 = R(R=200ohm)
  STEP1 = STEP(AMPL=100 T0=1s Y0=250)
  STEP2 = STEP(AMPL=3 T0=1s Y0=0)
  abc2dq0_1 = abc2dq0(i_b=AM2.I i_a=AM1.I i_c=AM3.I phi_e=motor_pm1.phi_eo)
  SUM1 = SUM(Invert[0]=true Invert[1]=false Invert[2]=false Invert[3]=false Invert[4]=false Invert[5]=false Invert[6]=false Invert[7]=false INPUT[0]=abc2dq0_1.i_d INPUT[1]=STEP2.VAL)
  INTG1 = INTG(INPUT=SUM1.VAL KI=1)
  GAIN15 = GAIN(INPUT=SUM1.VAL KP=0.11257)
  SUM3 = SUM(Invert[0]=false Invert[1]=false Invert[2]=false Invert[3]=false Invert[4]=false Invert[5]=false Invert[6]=false Invert[7]=false INPUT[1]=INTG1.VAL INPUT[0]=GAIN15.VAL)
  SUM15 = SUM(Invert[0]=true Invert[1]=false Invert[2]=false Invert[3]=false Invert[4]=false Invert[5]=false Invert[6]=false Invert[7]=false INPUT[1]=STEP1.VAL INPUT[0]=motor_pm1.rpm)
  GAIN10 = GAIN(INPUT=SUM15.VAL KP=0.038805)
  INTG3 = INTG(INPUT=SUM15.VAL KI=0.38805)
  SUM2 = SUM(Invert[0]=false Invert[1]=false Invert[2]=false Invert[3]=false Invert[4]=false Invert[5]=false Invert[6]=false Invert[7]=false INPUT[0]=GAIN10.VAL INPUT[1]=INTG3.VAL)
  SUM13 = SUM(Invert[0]=false Invert[1]=true Invert[2]=false Invert[3]=false Invert[4]=false Invert[5]=false Invert[6]=false Invert[7]=false INPUT[1]=abc2dq0_1.i_q INPUT[0]=SUM2.VAL)
  GAIN11 = GAIN(INPUT=SUM13.VAL KP=0.11257)
  INTG2 = INTG(INPUT=SUM13.VAL KI=1)
  SUM4 = SUM(Invert[0]=false Invert[1]=false Invert[2]=false Invert[3]=false Invert[4]=false Invert[5]=false Invert[6]=false Invert[7]=false INPUT[0]=GAIN11.VAL INPUT[1]=INTG2.VAL)
  dq02abc2 = dq02abc(i_0=abc2dq0_1.i_0 phi_e=motor_pm1.phi_eo i_d=SUM3.VAL i_q=SUM4.VAL)
  COMP4 = COMP(INPUT=dq02abc2.i_c THRES=C2NC6.OUT VAL1=0 VAL2=4)
  GAIN13 = GAIN(INPUT=COMP4.VAL KP=4)
  IGBT9 = IGBT(CTRL=GAIN13.VAL)
  COMP8 = COMP(INPUT=COMP4.VAL VAL2=0 VAL1=1 THRES=1e-05)
  GAIN14 = GAIN(INPUT=COMP8.VAL KP=4)
  IGBT10 = IGBT(CTRL=GAIN14.VAL)
  COMP6 = COMP(INPUT=dq02abc2.i_b THRES=C2NC6.OUT VAL1=0 VAL2=4)
  GAIN5 = GAIN(INPUT=COMP6.VAL KP=4)
  IGBT8 = IGBT(CTRL=GAIN5.VAL)
  COMP9 = COMP(INPUT=COMP6.VAL VAL2=0 VAL1=1 THRES=1e-05)
  GAIN12 = GAIN(INPUT=COMP9.VAL KP=4)
  IGBT11 = IGBT(CTRL=GAIN12.VAL)
  COMP7 = COMP(INPUT=dq02abc2.i_a THRES=C2NC6.OUT VAL1=0 VAL2=4)
  GAIN3 = GAIN(INPUT=COMP7.VAL KP=4)
  IGBT7 = IGBT(CTRL=GAIN3.VAL)
  COMP1 = COMP(INPUT=COMP7.VAL VAL2=0 VAL1=1 THRES=1e-05)
  GAIN4 = GAIN(INPUT=COMP1.VAL KP=4)
  IGBT12 = IGBT(CTRL=GAIN4.VAL)
nets:
  0: R1.1
  net_10: AM2.I, abc2dq0_1.i_b
  net_11: AM1.I, abc2dq0_1.i_a
  net_12: COMP1.INPUT, GAIN3.INPUT, COMP7.VAL
  net_13: C2NC6.0, E4.1
  net_16: gnd1.0, E4.0
  net_17: VM10.1, VM11.1, VM9.1, gnd6.0
  net_18: R4.0, L4.1
  net_19: VM8.0, L4.0, VM9.0, IGBT12.0, IGBT7.1, D12.1, D7.0, lowpass_filter_elec1.0
  net_2: abc2dq0_1.i_0, dq02abc2.i_0
  net_20: GAIN3.VAL, IGBT7.CTRL
  net_21: VM8.1, VM11.0, L5.0, IGBT11.0, D11.1, D8.0, IGBT8.1
  net_22: E6.0, E5.1, gnd7.0
  net_23: IGBT9.CTRL, GAIN13.VAL
  net_24: GAIN5.VAL, IGBT8.CTRL
  net_25: IGBT7.0, D9.1, E6.1, D7.1, D8.1, IGBT9.0, IGBT8.0
  net_26: GAIN4.VAL, IGBT12.CTRL
  net_27: GAIN12.VAL, IGBT11.CTRL
  net_28: GAIN14.VAL, IGBT10.CTRL
  net_29: IGBT12.1, IGBT11.1, D10.0, D12.0, E5.0, D11.0, IGBT10.1
  net_3: AM3.I, abc2dq0_1.i_c
  net_30: GAIN12.INPUT, COMP9.VAL
  net_31: COMP1.VAL, GAIN4.INPUT
  net_32: GAIN14.INPUT, COMP8.VAL
  net_33: SUM1.INPUT[0], abc2dq0_1.i_d
  net_34: SUM13.INPUT[1], abc2dq0_1.i_q
  net_35: STEP1.VAL, SUM15.INPUT[1]
  net_36: GAIN10.INPUT, INTG3.INPUT, SUM15.VAL
  net_37: COMP4.INPUT, dq02abc2.i_c
  net_38: COMP6.INPUT, dq02abc2.i_b
  net_39: COMP7.INPUT, dq02abc2.i_a
  net_40: C2NC6.OUT, COMP7.THRES, COMP6.THRES, COMP4.THRES
  net_41: SUM2.INPUT[0], GAIN10.VAL
  net_42: SUM2.INPUT[1], INTG3.VAL
  net_43: SUM13.VAL, GAIN11.INPUT, INTG2.INPUT
  net_44: GAIN11.VAL, SUM4.INPUT[0]
  net_45: SUM4.INPUT[1], INTG2.VAL
  net_46: SUM3.INPUT[1], INTG1.VAL
  net_47: SUM1.VAL, GAIN15.INPUT, INTG1.INPUT
  net_48: AM3.1, motor_pm1.2
  net_5: VM10.0, L6.0, D10.1, D9.0, IGBT9.1, IGBT10.0
  net_52: AM1.1, motor_pm1.0
  net_60: R1.0, lowpass_filter_elec1.1
  net_61: SUM1.INPUT[1], STEP2.VAL
  net_62: motor_pm1.rpm, SUM15.INPUT[0]
  net_63: AM2.1, motor_pm1.1
  net_64: motor_pm1.phi_eo, abc2dq0_1.phi_e, dq02abc2.phi_e
  net_65: motor_pm1.3, MchRMas1.1
  net_68: R6.0, L6.1
  net_7: R5.0, L5.1
  net_73: SUM3.INPUT[0], GAIN15.VAL
  net_78: SUM2.VAL, SUM13.INPUT[0]
  net_8: COMP6.VAL, GAIN5.INPUT, COMP9.INPUT
  net_86: SUM3.VAL, dq02abc2.i_d
  net_87: SUM4.VAL, dq02abc2.i_q
  net_9: COMP8.INPUT, COMP4.VAL, GAIN13.INPUT
  net_93: R4.1, AM1.0
  net_94: R5.1, AM2.0
  net_95: R6.1, AM3.0
setups:
  TR: TransientData(2s, 10us, 1ms, false, "")
reports:
  SPWM: GAIN3.VAL, GAIN4.VAL, GAIN5.VAL, GAIN12.VAL, GAIN13.VAL, GAIN14.VAL vs Time on TR : TR
  Carrier: E4.V vs Time on TR : TR
  OuInverter: VM9.V, VM11.V, VM10.V vs Time on TR : TR
  current: AM1.I, AM2.I, AM3.I vs Time on TR : TR
  Current and Trigger: dq02abc2.i_a, dq02abc2.i_b, dq02abc2.i_c vs Time on TR : TR
  rotor angle: motor_pm1.phi_eo vs Time on TR : TR
  dqCurrent: abc2dq0_1.i_d, abc2dq0_1.i_q vs Time on TR : TR
  LowPass: R1.V vs Time on TR : TR
  Speed vs Reference: motor_pm1.rpm, STEP1.VAL vs Time on TR : TR
  d current vs Reference: abc2dq0_1.i_d, STEP2.VAL vs Time on TR : TR
  XY Plot 1: SUM2.VAL vs Time on TR : TR
